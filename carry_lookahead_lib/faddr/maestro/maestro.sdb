ADE simulation setup
Run mode: Single Run, Sweeps and Corners
Tests:
  project1_elec402_faddr_1: project1_elec402/faddr/schematic, simulator spectre
    Variables: Wn = 120n
