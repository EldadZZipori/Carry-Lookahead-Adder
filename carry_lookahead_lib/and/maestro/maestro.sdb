ADE simulation setup
Run mode: Single Run, Sweeps and Corners
Tests:
  project1_elec402_and_1: project1_elec402/and/schematic, simulator spectre
    Variables: Wn = 120n
