ADE simulation setup
Run mode: Single Run, Sweeps and Corners
Tests:
  project1_elec402_8bit_adder_1: project1_elec402/8bit_adder/schematic, simulator spectre
    Variables: Wn = 120n
