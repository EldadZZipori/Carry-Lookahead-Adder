ADE simulation setup
Test project1_elec402_carry_lookahead_comb_4bit_1: project1_elec402/carry_lookahead_comb_4bit/schematic, simulator spectre
  Models: /ubc/ece/data/cmc2/kits/GPDK45/gpdk045_v_6_0/gpdk045/../models/spectre/gpdk045.scs[mc]
  Variables: Wn = 120n
  Temperature: 27
  Stimulus c0: voltage pwlf dc=0 pwlfilter=  file=/ubc/ece/home/ugrads/e/eldadzz/Desktop/ELEC402/sig2.txt srcType=pwl
  Stimulus p0: voltage pwlf dc=0 pwlfilter=  file=/ubc/ece/home/ugrads/e/eldadzz/Desktop/ELEC402/sig1.txt srcType=pwl
  Stimulus g0: voltage pwlf dc=0 pwlfilter=  file=/ubc/ece/home/ugrads/e/eldadzz/Desktop/ELEC402/sig0.txt srcType=pwl
  Stimulus Vss: voltage dc dc=0 srcType=dc
  Stimulus Vdd: voltage dc dc=1 srcType=dc
  Stimulus p1: voltage pwlf dc=0 pwlfilter=  file=/ubc/ece/home/ugrads/e/eldadzz/Desktop/ELEC402/sig3.txt srcType=pwl
  Stimulus g1: voltage pwlf dc=0 pwlfilter=  file=/ubc/ece/home/ugrads/e/eldadzz/Desktop/ELEC402/sig4.txt srcType=pwl
  Stimulus p2: voltage pwlf dc=0 pwlfilter=  file=/ubc/ece/home/ugrads/e/eldadzz/Desktop/ELEC402/sig5.txt srcType=pwl
  Stimulus g2: voltage pwlf dc=0 pwlfilter=  file=/ubc/ece/home/ugrads/e/eldadzz/Desktop/ELEC402/sig6.txt srcType=pwl
  Stimulus p3: voltage pwlf dc=0 pwlfilter=  file=/ubc/ece/home/ugrads/e/eldadzz/Desktop/ELEC402/sig7.txt srcType=pwl
  Stimulus g3: voltage pwlf dc=0 pwlfilter=  file=/ubc/ece/home/ugrads/e/eldadzz/Desktop/ELEC402/sig8.txt srcType=pwl
  Analysis tran: stop=80n errpreset=moderate
  Signals: /c0, /p0, /g1, /p1, /g2, /p2, /g3, /p3, /c4, /c3, /c2, /c1, /g0
Run mode: Single Run, Sweeps and Corners
