ADE simulation setup
Test project1_elec402_inverter_1: project1_elec402/inverter/schematic, simulator spectre
  Models: /ubc/ece/data/cmc2/kits/GPDK45/gpdk045_v_6_0/gpdk045/../models/spectre/gpdk045.scs[mc]
  Variables: Wn = 120n
  Temperature: 27
  Stimulus Vss: voltage dc dc=0 srcType=dc
  Stimulus Vdd: voltage dc dc=1 srcType=dc
  Stimulus in: voltage pulse val0=0 val1=1 period=10ns srcType=pulse
  Analysis tran: stop=40n
  Signals: /in, /output
Run mode: Single Run, Sweeps and Corners
