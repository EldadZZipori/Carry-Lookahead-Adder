ADE simulation setup
Run mode: Single Run, Sweeps and Corners
Tests:
  project1_elec402_inverter_1: project1_elec402/inverter/schematic, simulator spectre
    Variables: Wn = 120n
