ADE simulation setup
Test project1_elec402_xor_1: project1_elec402/xor/schematic, simulator spectre
  Models: /ubc/ece/data/cmc2/kits/GPDK45/gpdk045_v_6_0/gpdk045/../models/spectre/gpdk045.scs[mc]
  Variables: Wn = 120n
  Temperature: 27
  Stimulus Vss: voltage dc dc=0 srcType=dc
  Stimulus Vdd: voltage dc dc=1 srcType=dc
  Stimulus a: voltage pulse dc=0 val0=0 val1=1 period=15n delay=0 srcType=pulse
  Stimulus b: voltage pulse dc=0 val0=0 val1=1 period=10ns delay=6ns srcType=pulse
  Analysis tran: stop=60n errpreset=moderate
  Signals: /a, /b, /output
Run mode: Single Run, Sweeps and Corners
