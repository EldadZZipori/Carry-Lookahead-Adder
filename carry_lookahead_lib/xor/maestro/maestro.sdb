ADE simulation setup
Run mode: Single Run, Sweeps and Corners
Tests:
  project1_elec402_xor_1: project1_elec402/xor/schematic, simulator spectre
    Variables: Wn = 120n
