ADE simulation setup
Test project1_elec402_carry_lookahead_adder_4bit_1: project1_elec402/carry_lookahead_adder_4bit/schematic, simulator spectre
  Models: /ubc/ece/data/cmc2/kits/GPDK45/gpdk045_v_6_0/gpdk045/../models/spectre/gpdk045.scs[mc]
  Variables: Wn = 120n
  Temperature: 27
  Stimulus c0: voltage pwlf dc=0 pwlfilter=  file=/ubc/ece/home/ugrads/e/eldadzz/Desktop/ELEC402/sig0.txt srcType=pwl
  Stimulus a0: voltage pwlf dc=0 pwlfilter=  file=/ubc/ece/home/ugrads/e/eldadzz/Desktop/ELEC402/sig1.txt srcType=pwl
  Stimulus b0: voltage pwlf dc=0 pwlfilter=  file=/ubc/ece/home/ugrads/e/eldadzz/Desktop/ELEC402/sig3.txt srcType=pwl
  Stimulus Vss: voltage dc dc=0 srcType=dc
  Stimulus Vdd: voltage dc dc=1 srcType=dc
  Stimulus b3: voltage pwlf dc=0 pwlfilter=  file=/ubc/ece/home/ugrads/e/eldadzz/Desktop/ELEC402/sig2.txt srcType=pwl
  Stimulus a3: voltage pwlf dc=0 pwlfilter=  file=/ubc/ece/home/ugrads/e/eldadzz/Desktop/ELEC402/sig4.txt srcType=pwl
  Stimulus b2: voltage pwlf dc=0 pwlfilter=  file=/ubc/ece/home/ugrads/e/eldadzz/Desktop/ELEC402/sig4.txt srcType=pwl
  Stimulus a2: voltage pwlf dc=0 pwlfilter=  file=/ubc/ece/home/ugrads/e/eldadzz/Desktop/ELEC402/sig5.txt srcType=pwl
  Stimulus b1: voltage pwlf dc=0 pwlfilter=  file=/ubc/ece/home/ugrads/e/eldadzz/Desktop/ELEC402/sig6.txt srcType=pwl
  Stimulus a1: voltage pwlf dc=0 pwlfilter=  file=/ubc/ece/home/ugrads/e/eldadzz/Desktop/ELEC402/sig7.txt srcType=pwl
  Analysis tran: stop=80n errpreset=moderate
  Signals: /c4, /s3, /s2, /s1, /s0, /b3, /a3, /b2, /a2, /b1, /a1, /b0, /a0, /c0
Run mode: Single Run, Sweeps and Corners
