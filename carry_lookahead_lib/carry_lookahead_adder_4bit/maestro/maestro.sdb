ADE simulation setup
Run mode: Single Run, Sweeps and Corners
Tests:
  project1_elec402_carry_lookahead_adder_4bit_1: project1_elec402/carry_lookahead_adder_4bit/schematic, simulator spectre
    Variables: Wn = 120n
